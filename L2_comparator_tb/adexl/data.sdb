ADE simulation setup
Run mode: Single Run, Sweeps and Corners
Tests:
  ADC_learn:L2_comparator_tb:1: ADC_learn/L2_comparator_tb/schematic, simulator spectre
Global variables:
  FCLK = 1G
  VTEST = 100u 1m 10m 100m 1
