ADE simulation setup
Run mode: Single Run, Sweeps and Corners
Tests:
  ADC_learn:L2_comparator_tb:1: ADC_learn/L2_comparator_tb/schematic, simulator spectre
    Outputs: Energy; T_cmp; T_rst; FoM1; FoM2
Global variables:
  FCLK = 1G
  VTEST = 1m
Device parameters:
  ADC_learn/L2_comparator/schematic/M0.simM = 4
  ADC_learn/L2_comparator/schematic/M1.simM = 20
  ADC_learn/L2_comparator/schematic/M2.simM = M1/simM@ADC_learn/L2_comparator/schematic
  ADC_learn/L2_comparator/schematic/M9.simM = 4
  ADC_learn/L2_comparator/schematic/M7.simM = M9/simM@ADC_learn/L2_comparator/schematic
  ADC_learn/L2_comparator/schematic/M10.simM = M9/simM@ADC_learn/L2_comparator/schematic
  ADC_learn/L2_comparator/schematic/M8.simM = M9/simM@ADC_learn/L2_comparator/schematic
  ADC_learn/L2_comparator/schematic/M3.simM = 2
  ADC_learn/L2_comparator/schematic/M4.simM = M3/simM@ADC_learn/L2_comparator/schematic
  ADC_learn/L2_comparator/schematic/M5.simM = M3/simM@ADC_learn/L2_comparator/schematic
  ADC_learn/L2_comparator/schematic/M6.simM = M3/simM@ADC_learn/L2_comparator/schematic
