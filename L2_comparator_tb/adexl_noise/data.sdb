ADE simulation setup
Run mode: Single Run, Sweeps and Corners
Tests:
  ADC_learn:L2_comparator_tb:1: ADC_learn/L2_comparator_tb/schematic, simulator spectre
    Outputs: percentage
Global variables:
  FCLK = 1G
  VTEST = {Inclusion List}100u 200u 300u 400u 500u 600u 700u 800u 900u 1m{Inclusion List}
