ADE simulation setup
Run mode: Single Run, Sweeps and Corners
Tests:
  ADC_learn:L2_comparator_offset_tb:1: ADC_learn/L2_comparator_offset_tb/schematic, simulator spectre
    Outputs: vos
Global variables:
  FCLK = 1G
  cap = 0
Corners (nominal off):
  model folders: /home/minlei/Desktop/project_tsmc18/pdk_tsmc18/tsmc18_1p5m_1fF/tsmc18/../models/spectre
  C0: cmn018_assp_v1d2.scs[mc]
