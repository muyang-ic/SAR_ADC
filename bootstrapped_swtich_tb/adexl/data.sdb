ADE simulation setup
Run mode: Single Run, Sweeps and Corners
Tests:
  ADC_learn:bootstrapped_swtich_tb:1: ADC_learn/bootstrapped_swtich_tb/config, simulator spectre
    Outputs: gate; (VT("/I0/up") - VT("/I0/bottom"))
Global variables:
  Fs = 10M
  VDD = 1.8
