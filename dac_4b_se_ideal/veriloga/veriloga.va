`include "constants.vams"
`include "disciplines.vams"

`define NUM_ADC_BITS 4
`default_transition 30p

module va_dac_4b_se(
    input electrical [`NUM_ADC_BITS:1] DIN,
    input electrical RDY,
    output electrical AOUT
);

    real weight[`NUM_ADC_BITS:1] = {4, 2, 1, 0.5};
    real sum;

    parameter real vdd = 1;
    parameter real vth = 0.5;

    real aout;
    genvar i;

    analog begin

        // Reset and calculate the total normalization weight
        @(initial_step) begin
            sum = weight[1];

            for (i = `NUM_ADC_BITS; i >= 1; i = i - 1) begin
                sum = sum + weight[i];
            end
        end

        // Update when ADC digital output code is ready
        @(cross(V(RDY) - vth, +1)) begin
            aout = 0;

            for (i = `NUM_ADC_BITS; i >= 1; i = i - 1) begin
                aout = aout
                     + (V(DIN[i]) > vth) * weight[i];
            end

            aout = (aout / sum) * vdd;
        end

        V(AOUT) <+ transition(aout, 0);

    end

endmodule
