ADE simulation setup
Run mode: Monte Carlo Sampling
Tests:
  ADC_learn:L2_comparator_mc:1: ADC_learn/L2_comparator_mc/schematic, simulator spectre
Global variables:
  cap = 1f
  FCLK = 1G
Corners (nominal off):
  model folders: /home/minlei/Desktop/project_tsmc18/pdk_tsmc18/tsmc18_1p5m_1fF/tsmc18/../models/spectre
  C1: cmn018_assp_v1d2.scs[mc]
Monte Carlo Sampling options: mcmethod=mismatch, mcnumpoints=200
