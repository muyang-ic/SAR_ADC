// VerilogA for ADC_learn, L2_logic_4b_async, veriloga

`include "constants.vams"
`include "disciplines.vams"

`define NUM_ADC_BITS 4
`default_transition 10p

module L2_logic_4b_async_CDAC (input electrical CLKS, input electrical CLKC, input electrical DCMPP, input electrical DCMPN,
output electrical [`NUM_ADC_BITS-1 : 1] DCTRLN, output electrical [`NUM_ADC_BITS-1 : 1] DCTRLP, output electrical [`NUM_ADC_BITS-1 : 0] DO, output electrical CMPCK);

parameter real vdd = 1, t_logic_delay  = 200p;
integer step, cmpck;
integer dctrlp [`NUM_ADC_BITS-1 : 1], dctrln [`NUM_ADC_BITS-1 : 1], dout[`NUM_ADC_BITS-1 : 0];
genvar i;

analog begin
	// initialization and reset when CLKS goes up
	@(initial_step or cross(V(CLKS) - vdd/2, +1)) begin
		step = `NUM_ADC_BITS-1;
		cmpck = 0;
		for (i = 1; i <= `NUM_ADC_BITS - 1; i = i+1) begin
			dctrlp[i] = 0; dctrln[i] = 0;
		end
		dctrlp[`NUM_ADC_BITS - 1] = 1;
		dctrln[`NUM_ADC_BITS - 1] = 1;
		$strobe("[Reset]");
	end

	// CDAD sample at CLKS falling edge

	// start SAR conversion
	@(cross(V(CLKC) - vdd/2, +1)) begin
		cmpck = 1; //comparator starts first comparison
		$strobe("[cmpck goes up]");
	end

	// comparator output occuring, close and reset the comparator
	@(cross(V(DCMPP) - vdd/2, +1) or cross(V(DCMPN) - vdd/2, +1)) begin
		$strobe("[step = %d] cmp output up", step);

		//close comparator
		cmpck = 0;
		$strobe("[cmpck goes down]");

		//generate digital output code for the current bit
		if (step >= 0) begin
			dout[step] = V(DCMPP) > V(DCMPN);
		end

		//control CDAC
		if (step >= 1) begin
			if(step == `NUM_ADC_BITS - 1) begin
				if(dout[step] > vdd/2) begin
					dctrln[step] = 0;
				end else begin
					dctrlp[step] = 0;
				end
			end else begin
			if(dout[step] == 1) begin
				dctrlp[step] = 1;
			end else begin
				dctrln[step] = 1;
			end
		end
		end
	end

	//comparator output reeset
	@(cross(V(DCMPP) - vdd/2, -1) or cross(V(DCMPN) - vdd/2, -1)) begin
		$strobe("[step = %d] cmp output down\n", step);
		step = step - 1;
		// activate comparator for the next comparison
		if(step >= 0) begin
			cmpck = 1;
			$strobe("[cmpck goes up]");
		end
	end

	//output voltage assignment
	V(CMPCK) <+ transition(cmpck*vdd, t_logic_delay);

	for(i = 1; i <= `NUM_ADC_BITS - 1; i = i+1) begin
		V(DCTRLP[i]) <+ transition( dctrlp[i] * vdd, 0);
		V(DCTRLN[i]) <+ transition( dctrln[i] * vdd, 0);
	end
	for(i = 0; i <= `NUM_ADC_BITS - 1; i = i+1) begin
		V(DO[i]) <+ transition(dout[i] * vdd, 0);
	end
end

endmodule
